* LTspice Export: 600V to 5V Detector
* Generated by SolverSCH

VVin in 0 DC 600.0
RR_h1 in n1 400000.0
RR_h2 n1 n2 400000.0
RR_h3 n2 div 390000.0
RR_low div 0 10000.0
EU1 out 0 div out 1000000.0
VVcc vcc 0 DC 15.0
VVee vee 0 DC -15.0

.model D_MODEL D(Is=1e-14 n=1)
.model NPN_MODEL NPN(Bf=100 Vaf=50)
.model PNP_MODEL PNP(Bf=100 Vaf=50)
.model NMOS_MODEL NMOS(Kp=100e-6 Vto=1)
.model PMOS_MODEL PMOS(Kp=50e-6 Vto=-1)

.op
.probe V(*) I(*)
.save all
.end
