* SolverSCH Validation - RLC Filter + OpAmp Buffer
V1 in 0 AC 1.0
R1 in node_l 100
L1 node_l node_c 1mH
C1 node_c 0 1uF
* Ideal OpAmp modeled as a Voltage Controlled Voltage Source (VCVS) with high gain
E1 out 0 node_c 0 1E6

.ac dec 10 100 100k
.probe
.end
