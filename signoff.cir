* LTspice Export: OpAmp_Test
* Generated by SolverSCH

VVin in_p 0 SINE(1.0 0.0 0.0) AC 0.0 0.0
EU1 out 0 in_p in_n 100000.0
RRf out in_n 10000
RRg in_n 0 1000

.model D_MODEL D(Is=1e-14 n=1)
.model NPN_MODEL NPN(Bf=100 Vaf=50)
.model PNP_MODEL PNP(Bf=100 Vaf=50)
.model NMOS_MODEL NMOS(Kp=100e-6 Vto=1)
.model PMOS_MODEL PMOS(Kp=50e-6 Vto=-1)

.op
.probe V(*) I(*)
.save all
.end
