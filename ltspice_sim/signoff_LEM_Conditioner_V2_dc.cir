* LTspice Export: LEM Conditioner V2
* Generated by SolverSCH

VV_REF vref 0 DC 3.3
RR_div1 vref v_offset 10000.0
RR_div2 v_offset 0 10000.0
EU_BUF v_offset_buf 0 v_offset v_offset_buf 1000000.0
RR_burden adc_in v_offset_buf 66.0

.model D_MODEL D(Is=1e-14 n=1)
.model NPN_MODEL NPN(Bf=100 Vaf=50)
.model PNP_MODEL PNP(Bf=100 Vaf=50)
.model NMOS_MODEL NMOS(Kp=100e-6 Vto=1)
.model PMOS_MODEL PMOS(Kp=50e-6 Vto=-1)

.op
.probe V(*) I(*)
.save all
.end
