* LTspice Export: Diode Crossval Models
* Generated by SolverSCH

VV1 in 0 DC 5.0
RR1 in mid 1000.0
DD1 mid 0 1N4148

.model D_MODEL D(Is=1e-14 n=1)
.model NPN_MODEL NPN(Bf=100 Vaf=50)
.model PNP_MODEL PNP(Bf=100 Vaf=50)
.model NMOS_MODEL NMOS(Kp=100e-6 Vto=1)
.model PMOS_MODEL PMOS(Kp=50e-6 Vto=-1)
* Custom Models from Circuit Registry:
.model 1N4148 D(Is=2.52n Rs=0.568 N=1.752 Cjo=4p M=0.4 tt=20n)

.op
.probe V(*) I(*)
.save all
.end
