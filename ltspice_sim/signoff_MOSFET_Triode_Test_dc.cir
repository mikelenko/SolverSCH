* LTspice Export: MOSFET Triode Test
* Generated by SolverSCH

VVDD vd 0 DC 10.0
VVGG vg 0 DC 5.0
RRD vd drain 1000.0
MM1 drain vg 0 0 BS170

.model D_MODEL D(Is=1e-14 n=1)
.model NPN_MODEL NPN(Bf=100 Vaf=50)
.model PNP_MODEL PNP(Bf=100 Vaf=50)
.model NMOS_MODEL NMOS(Kp=100e-6 Vto=1)
.model PMOS_MODEL PMOS(Kp=50e-6 Vto=-1)
* Custom Models from Circuit Registry:
.model BS170 NMOS(VTO=2.0 KP=0.1 LAMBDA=0.01)

.op
.probe V(*) I(*)
.save all
.end
