* LTspice Export: RC LP Filter 1kHz (fallback)
* Generated by SolverSCH

VVin in 0 SINE(0.0 1.0 1000) AC 1.0 0.0
RR1 in out 15000
CC1 out 0 1e-08

.model D_MODEL D(Is=1e-14 n=1)
.model NPN_MODEL NPN(Bf=100 Vaf=50)
.model PNP_MODEL PNP(Bf=100 Vaf=50)
.model NMOS_MODEL NMOS(Kp=100e-6 Vto=1)
.model PMOS_MODEL PMOS(Kp=50e-6 Vto=-1)

.tran 5e-06 0.003 0 5e-06
.probe V(*) I(*)
.save all
.end
